** sch_path: /foss/designs/BGR_TOP_NSL/BGR_NSL/NOT.sch
.subckt NOT vdd in out vss
*.PININFO vdd:B vss:B in:I out:O
XM6 out in vss vss sky130_fd_pr__nfet_01v8_lvt L=1 W=1 nf=1
XM1 out in vdd vdd sky130_fd_pr__pfet_01v8_lvt L=1 W=2 nf=2
.ends
