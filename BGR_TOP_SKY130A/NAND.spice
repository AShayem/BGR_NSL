** sch_path: /foss/designs/BGR_TOP_NSL/BGR_NSL/NAND.sch
.subckt NAND vdd out A B C vss
*.PININFO vdd:B vss:B A:I C:I B:I out:O
M6 out A net1 vss sky130_fd_pr__nfet_01v8_lvt L=1 W=2 nf=2
M1 out B vdd vdd sky130_fd_pr__pfet_01v8_lvt L=1 W=4 nf=4
M2 out A vdd vdd sky130_fd_pr__pfet_01v8_lvt L=1 W=4 nf=4
M3 net1 B net2 vss sky130_fd_pr__nfet_01v8_lvt L=1 W=2 nf=2
M4 out C vdd vdd sky130_fd_pr__pfet_01v8_lvt L=1 W=4 nf=4
M5 net2 C vss vss sky130_fd_pr__nfet_01v8_lvt L=1 W=2 nf=2
M7 net1 vss vss vss sky130_fd_pr__nfet_01v8_lvt L=1 W=1 nf=1
.ends
